| / 7\'7
| \ \   Xilinx Inc.
| / /
| \_\/.\   IBIS Models for Spartan-3E
[IBIS ver]   3.2
[File name]   pop_cpu.ibs
[File Rev]   1.5
[Date]   Wed Nov 30 16:00:46 2016
[Source]   HSPICE simulations
[Notes]   IBIS models for Spartan-3E
[Disclaimer]
|   The data in this model is derived from SPICE simulations using
|   modeling information extracted from the target process. While
|   a great deal of care has been taken to provide information
|   that is accurate, this model is considered preliminary as it
|   has not been verified by actual silicon measurement. Treat the
|   data in this model as preliminary until actual silicon
|   verification is performed.
|   To accurately model package parasitics, please follow the
|   instructions at:  http://www.xilinx.com/xlnx/
|   xil_ans_display.jsp?getPagePath=11754
|   LVDS and LVPECL drivers require the use of external
|   termination resistors to provide the correct voltage levels.
|   For more information, refer to the Spartan-3 documentation.
|   NOTE: This file is compliant with IBIS Version 3.2, but it
|   may not implement all approved 3.2 features.
|   NOTE:  Newer versions of the buffer models may be available.
|   Check the web (http://www.xilinx.com/support/sw_ibis.htm) for
|   the latest file revision.  However, please be aware that the
|   web files are not compatible for use with IBISWriter, and
|   must be manually annotated, should their use be preferred.
[Copyright]
| Copyright 2006, Xilinx Inc., All rights reserved
|   Component Spartan-3E
[Component]   Spartan-3E
[Manufacturer]   Xilinx Inc.
[Package]
| For Package Type fg320
| variable   typ   min   max
R_pkg   279.84m   143.60m   397.60m
L_pkg   5.05nH   2.59nH   7.05nH
C_pkg   0.88pF   0.46pF   1.61pF
[Pin]  signal_name   model_name   R_pin   L_pin   C_pin
R16   Ram2Addr<7>   LVCMOS25_S_12_O
R18   Ram2Addr<8>   LVCMOS25_S_12_O
T17   Ram2Addr<9>   LVCMOS25_S_12_O
U13   Ram2Data<0>   LVCMOS25_S_12
T16   Ram2Data<1>   LVCMOS25_S_12
T15   Ram2Data<2>   LVCMOS25_S_12
T14   Ram2Data<3>   LVCMOS25_S_12
T12   Ram2Data<4>   LVCMOS25_S_12
R13   Ram2Data<5>   LVCMOS25_S_12
R14   Ram2Data<6>   LVCMOS25_S_12
R12   Ram2Data<7>   LVCMOS25_S_12
R11   Ram2Data<8>   LVCMOS25_S_12
R10   Ram2Data<9>   LVCMOS25_S_12
C14   rdn   LVCMOS25_S_12_O
U5   wrn   LVCMOS25_S_12_O
G13   RAM1addr<10>   LVCMOS25_S_12_O
G14   RAM1addr<11>   LVCMOS25_S_12_O
G15   RAM1addr<12>   LVCMOS25_S_12_O
G16   RAM1addr<13>   LVCMOS25_S_12_O
H14   RAM1addr<14>   LVCMOS25_S_12_O
H15   RAM1addr<15>   LVCMOS25_S_12_O
H16   RAM1addr<16>   LVCMOS25_S_12_O
H17   RAM1addr<17>   LVCMOS25_S_12_O
A16   dataReady   LVCMOS25_S_12_I
L15   RAM1data<10>   LVCMOS25_S_12
L16   RAM1data<11>   LVCMOS25_S_12
L17   RAM1data<12>   LVCMOS25_S_12
L18   RAM1data<13>   LVCMOS25_S_12
M13   RAM1data<14>   LVCMOS25_S_12
M14   RAM1data<15>   LVCMOS25_S_12
N9   tsre   LVCMOS25_S_12_I
C7   l7<0>   LVCMOS25_S_12_O
D7   l7<1>   LVCMOS25_S_12_O
E7   l7<2>   LVCMOS25_S_12_O
F7   l7<3>   LVCMOS25_S_12_O
A8   l7<4>   LVCMOS25_S_12_O
E8   l7<5>   LVCMOS25_S_12_O
F8   l7<6>   LVCMOS25_S_12_O
C9   r7<0>   LVCMOS25_S_12_O
D9   r7<1>   LVCMOS25_S_12_O
E9   r7<2>   LVCMOS25_S_12_O
F9   r7<3>   LVCMOS25_S_12_O
G9   r7<4>   LVCMOS25_S_12_O
A10   r7<5>   LVCMOS25_S_12_O
B10   r7<6>   LVCMOS25_S_12_O
F12   ins<10>   LVCMOS25_S_12_O
A13   ins<11>   LVCMOS25_S_12_O
B13   ins<12>   LVCMOS25_S_12_O
D13   ins<13>   LVCMOS25_S_12_O
E13   ins<14>   LVCMOS25_S_12_O
A14   ins<15>   LVCMOS25_S_12_O
U9   inclk   LVCMOS25_S_12_I
M15   RAM1EN   LVCMOS25_S_12_O
M16   RAM1OE   LVCMOS25_S_12_O
M18   RAM1WE   LVCMOS25_S_12_O
C17   RAM1addr<0>   LVCMOS25_S_12_O
C18   RAM1addr<1>   LVCMOS25_S_12_O
D16   RAM1addr<2>   LVCMOS25_S_12_O
D17   RAM1addr<3>   LVCMOS25_S_12_O
E15   RAM1addr<4>   LVCMOS25_S_12_O
E16   RAM1addr<5>   LVCMOS25_S_12_O
F14   RAM1addr<6>   LVCMOS25_S_12_O
F15   RAM1addr<7>   LVCMOS25_S_12_O
F17   RAM1addr<8>   LVCMOS25_S_12_O
F18   RAM1addr<9>   LVCMOS25_S_12_O
N10   Ram2EN   LVCMOS25_S_12_O
R9   Ram2OE   LVCMOS25_S_12_O
M9   Ram2WE   LVCMOS25_S_12_O
J12   RAM1data<0>   LVCMOS25_S_12
J13   RAM1data<1>   LVCMOS25_S_12
J14   RAM1data<2>   LVCMOS25_S_12
J15   RAM1data<3>   LVCMOS25_S_12
J16   RAM1data<4>   LVCMOS25_S_12
J17   RAM1data<5>   LVCMOS25_S_12
K12   RAM1data<6>   LVCMOS25_S_12
K13   RAM1data<7>   LVCMOS25_S_12
K14   RAM1data<8>   LVCMOS25_S_12
K15   RAM1data<9>   LVCMOS25_S_12
T18   Ram2Addr<10>   LVCMOS25_S_12_O
U18   Ram2Addr<11>   LVCMOS25_S_12_O
V15   Ram2Addr<12>   LVCMOS25_S_12_O
V13   Ram2Addr<13>   LVCMOS25_S_12_O
V12   Ram2Addr<14>   LVCMOS25_S_12_O
V9   Ram2Addr<15>   LVCMOS25_S_12_O
U16   Ram2Addr<16>   LVCMOS25_S_12_O
U15   Ram2Addr<17>   LVCMOS25_S_12_O
D10   ins<0>   LVCMOS25_S_12_O
E10   ins<1>   LVCMOS25_S_12_O
A11   ins<2>   LVCMOS25_S_12_O
B11   ins<3>   LVCMOS25_S_12_O
C11   ins<4>   LVCMOS25_S_12_O
D11   ins<5>   LVCMOS25_S_12_O
E11   ins<6>   LVCMOS25_S_12_O
F11   ins<7>   LVCMOS25_S_12_O
A12   ins<8>   LVCMOS25_S_12_O
E12   ins<9>   LVCMOS25_S_12_O
P13   Ram2Data<10>   LVCMOS25_S_12
P12   Ram2Data<11>   LVCMOS25_S_12
P11   Ram2Data<12>   LVCMOS25_S_12
P10   Ram2Data<13>   LVCMOS25_S_12
N12   Ram2Data<14>   LVCMOS25_S_12
N11   Ram2Data<15>   LVCMOS25_S_12
N14   Ram2Addr<0>   LVCMOS25_S_12_O
N15   Ram2Addr<1>   LVCMOS25_S_12_O
N18   Ram2Addr<2>   LVCMOS25_S_12_O
P16   Ram2Addr<3>   LVCMOS25_S_12_O
P17   Ram2Addr<4>   LVCMOS25_S_12_O
P18   Ram2Addr<5>   LVCMOS25_S_12_O
R15   Ram2Addr<6>   LVCMOS25_S_12_O
B1   PROG_B   LVCMOS25_S_12
C1   IO_L01P_3   NC
C2   IO_L01N_3   NC
D1   IO_L02P_3   NC
D2   IO_L02N_3/VREF_3   NC
D3   IP   NC
D4   IO   NC
E2   IO_L03P_3   NC
E1   IO_L03N_3   NC
F4   IP   NC
E4   IO_L04P_3   NC
E3   IO_L04N_3   NC
F5   IP   NC
F1   IO_L05P_3   NC
F2   IO_L05N_3   NC
G3   IO_L06P_3   NC
G4   IO_L06N_3/VREF_3   NC
G1   IP   NC
G6   IO_L07P_3   NC
G5   IO_L07N_3   NC
H6   IO_L08P_3   NC
H5   IO_L08N_3   NC
J7   IP   NC
H4   IO_L09P_3   NC
H3   IO_L09N_3   NC
H2   IO_L10P_3   NC
H1   IO_L10N_3   NC
J6   IP/VREF_3   NC
J5   LHCLK0   NC
J4   LHCLK1   NC
J1   LHCLK2   NC
J2   LHCLK3/IRDY2   NC
K2   IP   NC
K3   LHCLK4/TRDY2   NC
K4   LHCLK5   NC
K6   LHCLK6   NC
K5   LHCLK7   NC
K7   IP   NC
L1   IO_L15P_3   NC
L2   IO_L15N_3   NC
L3   IO_L16P_3   NC
L4   IO_L16N_3   NC
M1   IP   NC
L6   IO_L17P_3   NC
L5   IO_L17N_3/VREF_3   NC
M4   IO_L18P_3   NC
M3   IO_L18N_3   NC
N1   IP   NC
M5   IO_L19P_3   NC
M6   IO_L19N_3   NC
N4   IO_L20P_3   NC
N5   IO_L20N_3   NC
N2   IP   NC
P2   IO_L21P_3   NC
P1   IO_L21N_3   NC
R4   IP/VREF_3   NC
P3   IO_L22P_3   NC
P4   IO_L22N_3   NC
R1   IP   NC
R3   IO_L23P_3   NC
R2   IO_L23N_3   NC
T2   IO_L24P_3   NC
T1   IO_L24N_3   NC
U1   IP   NC
V2   IP   NC
U3   CSO_B   LVCMOS25_S_12
T3   INIT_B   LVCMOS25_S_12
V4   IP_L02P_2   NC
V3   IP_L02N_2   NC
U4   DOUT/BUSY   NC
T4   MOSI/CSI_B   LVCMOS25_S_12
R5   IO_L04P_2   NC
T5   IO_L04N_2   NC
R6   IO_L05P_2   NC
P6   IO_L05N_2   NC
V5   IO_L06P_2   NC
V6   IO_L06N_2/VREF_2   NC
U6   IO   NC
N7   IO_L07P_2   NC
P7   IO_L07N_2   NC
V7   IO   NC
T7   IP_L08P_2   NC
R7   IP_L08N_2   NC
P8   IO_L09P_2   NC
N8   IO_L09N_2   NC
P9   IO   NC
R8   IO_L10P_2   NC
T8   IO_L10N_2   NC
U8   IP_L11P_2   NC
V8   IP_L11N_2/VREF_2   NC
U10   RDWR_B/GCLK0   LVCMOS25_S_12
T10   M2/GCLK1   LVCMOS25_S_12
V11   M1   LVCMOS25_S_12
M10   M0   LVCMOS25_S_12
T11   IP_L17P_2   NC
U11   IP_L17N_2   NC
V14   IP_L23P_2   NC
U14   IP_L23N_2   NC
V16   IP   NC
V17   DONE   LVCMOS25_S_12
R17   IP   NC
P15   IP   NC
N17   IP   NC
L14   IP   NC
L13   IP   NC
K17   IP   NC
K18   IP   NC
H18   IP/VREF_1   NC
G18   IP   NC
H13   IP   NC
E18   IP   NC
E17   IP   NC
D18   IP/VREF_1   NC
B18   IP   NC
D15   TMS   LVCMOS25_S_12
C16   TDO   LVCMOS25_S_12
A17   TCK   LVCMOS25_S_12
C15   IP   NC
B16   IO_L01P_0   NC
B15   IP_L02P_0   NC
A15   IP_L02N_0   NC
D14   IO_L03P_0   NC
B14   IO_L04P_0   NC
C12   IP_L07P_0   NC
D12   IP_L07N_0   NC
F10   IP_L10P_0   NC
G10   IP_L10N_0   NC
B8   GCLK8   NC
B9   GCLK9   NC
C8   IP_L16P_0   NC
D8   IP_L16N_0   NC
A7   IO   NC
B6   IO_L20P_0   NC
A6   IO_L20N_0   NC
D6   IO_L21P_0   NC
E6   IO_L21N_0   NC
A5   IP_L22P_0   NC
B5   IP_L22N_0   NC
C5   IO_L23P_0   NC
D5   IO_L23N_0/VREF_0   NC
C4   IO   NC
A4   IO_L24P_0   NC
B4   IO_L24N_0   NC
A3   IP   NC
C3   IO_L25P_0   NC
B3   HSWAP   LVCMOS25_S_12
A2   TDI   LVCMOS25_S_12
A1   GND   GND
B2   GND   GND
A18   GND   GND
B17   GND   GND
V1   GND   GND
U2   GND   GND
V18   GND   GND
U17   GND   GND
C10   GND   GND
G7   GND   GND
G12   GND   GND
H8   GND   GND
H9   GND   GND
H10   GND   GND
H11   GND   GND
J8   GND   GND
K8   GND   GND
J11   GND   GND
K11   GND   GND
L8   GND   GND
L9   GND   GND
L10   GND   GND
L11   GND   GND
M7   GND   GND
M12   GND   GND
J3   GND   GND
K16   GND   GND
T9   GND   GND
B7   VCCAUX   POWER
B12   VCCAUX   POWER
G2   VCCAUX   POWER
M2   VCCAUX   POWER
G17   VCCAUX   POWER
M17   VCCAUX   POWER
U7   VCCAUX   POWER
U12   VCCAUX   POWER
A9   VCCO_0   POWER
C6   VCCO_0   POWER
C13   VCCO_0   POWER
G8   VCCO_0   POWER
G11   VCCO_0   POWER
J18   VCCO_1   POWER
F16   VCCO_1   POWER
N16   VCCO_1   POWER
H12   VCCO_1   POWER
L12   VCCO_1   POWER
V10   VCCO_2   POWER
T6   VCCO_2   POWER
T13   VCCO_2   POWER
M8   VCCO_2   POWER
M11   VCCO_2   POWER
K1   VCCO_3   POWER
F3   VCCO_3   POWER
N3   VCCO_3   POWER
H7   VCCO_3   POWER
L7   VCCO_3   POWER
E5   VCCINT   POWER
F6   VCCINT   POWER
E14   VCCINT   POWER
F13   VCCINT   POWER
N6   VCCINT   POWER
P5   VCCINT   POWER
N13   VCCINT   POWER
P14   VCCINT   POWER
| Models and submodels in the file (3): LVCMOS25_S_12 (I/O), LVCMOS25_S_12_I (Input), LVCMOS25_S_12_O (Output)
